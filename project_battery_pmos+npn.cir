* C:\Users\user\Documents\PSpice\project_battery_pmos+npn.sch

* Schematics Version 9.2
* Thu Aug 06 17:01:38 2026

** Analysis setup **
.tran 50m 5 0 50m
.OP

* From [PSPICE NETLIST] section of c:\orcad\PSpice\PSpice.ini:
.lib "nom.lib"

.INC "project_battery_pmos+npn.net"

.PROBE V(*) I(*) W(*) D(*) NOISE(*)

.END
